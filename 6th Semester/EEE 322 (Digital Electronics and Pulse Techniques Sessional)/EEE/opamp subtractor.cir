* C:\Users\hrido\OneDrive\Desktop\EEE\opamp subtractor.sch

* Schematics Version 9.1 - Web Update 1
* Thu Apr 16 00:37:29 2026

** Analysis setup **
.tran 0ns 2.5s
.OP

* From [PSPICE NETLIST] section of pspiceev.ini:
.lib "nom.lib"

.INC "opamp subtractor.net"
.INC "opamp subtractor.als"

.probe

.END
