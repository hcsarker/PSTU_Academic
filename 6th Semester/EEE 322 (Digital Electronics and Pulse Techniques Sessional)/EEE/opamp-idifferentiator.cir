* C:\Users\hrido\OneDrive\Desktop\EEE\opamp-idifferentiator.sch

* Schematics Version 9.1 - Web Update 1
* Thu Apr 16 00:58:04 2026

** Analysis setup **
.tran 0ns 2.5s
.OP

* From [PSPICE NETLIST] section of pspiceev.ini:
.lib "nom.lib"

.INC "opamp-idifferentiator.net"
.INC "opamp-idifferentiator.als"

.probe

.END
