* C:\Users\hrido\OneDrive\Desktop\EEE\clamper.sch

* Schematics Version 9.1 - Web Update 1
* Thu Apr 16 02:45:50 2026

** Analysis setup **
.tran 0ns 2s
.OP

* From [PSPICE NETLIST] section of pspiceev.ini:
.lib "nom.lib"

.INC "clamper.net"
.INC "clamper.als"

.probe

.END
