* C:\Users\hrido\OneDrive\Desktop\EEE\clipper  shunt.sch

* Schematics Version 9.1 - Web Update 1
* Thu Apr 16 02:20:01 2026

** Analysis setup **
.tran 0ns 2s
.OP

* From [PSPICE NETLIST] section of pspiceev.ini:
.lib "nom.lib"

.INC "clipper  shunt.net"
.INC "clipper  shunt.als"

.probe

.END
